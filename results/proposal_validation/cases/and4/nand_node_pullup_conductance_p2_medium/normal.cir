AND4 normal truth-table and delay verification
* Four-input CMOS AND, pedagogical Level-1 devices, 3.3 V.
.subckt dut a b c d out vdd vss
M1 n1 a vdd vdd PM W=8u L=1u
M2 n1 b vdd vdd PM W=8u L=1u
M3 n1 c vdd vdd PM W=8u L=1u
M4 n1 d vdd vdd PM W=8u L=1u
M5 n1 a n2 vss NM W=16u L=1u
M6 n2 b n3 vss NM W=16u L=1u
M7 n3 c n4 vss NM W=16u L=1u
M8 n4 d vss vss NM W=16u L=1u
M9 out n1 vdd vdd PM W=8u L=1u
M10 out n1 vss vss NM W=4u L=1u
C1 out vss 100f
C31 a n32 0.5p
D31 n32 n31 DJ31
D32 vss n32 DJ31
C32 n31 vss 10p
R31 n31 vss 4000000
B31 n1 vdd I={v(n1,vdd)/200*((1+tanh((v(n31,vss)-1)/0.025))/2)}
.ends dut
.model NM NMOS (LEVEL=1 VTO=0.6 KP=120u LAMBDA=0.02 CGSO=100p CGDO=100p)
.model PM PMOS (LEVEL=1 VTO=-0.6 KP=50u LAMBDA=0.02 CGSO=100p CGDO=100p)

.model DJ31 D (IS=1e-12 N=1)

VDD vdd 0 3.3
X1 a b c d out vdd 0 dut
Va a 0 PWL(0 0 2e-05 0 2.00001e-05 0 4e-05 0 4.00001e-05 3.3 6e-05 3.3 6.00001e-05 0 8e-05 0 8.00001e-05 3.3 0.0001 3.3 0.0001000001 0 0.00012 0 0.0001200001 3.3 0.00014 3.3 0.0001400001 0 0.00016 0 0.0001600001 3.3 0.00018 3.3 0.0001800001 0 0.0002 0 0.0002000001 3.3 0.00022 3.3 0.0002200001 0 0.00024 0 0.0002400001 3.3 0.00026 3.3 0.0002600001 0 0.00028 0 0.0002800001 3.3 0.0003 3.3 0.0003000001 0 0.00032 0 0.0003200001 3.3 0.00034 3.3 0.0003400001 0 0.00036 0)
Vb b 0 PWL(0 0 2e-05 0 2.00001e-05 0 4e-05 0 4.00001e-05 0 6e-05 0 6.00001e-05 3.3 8e-05 3.3 8.00001e-05 3.3 0.0001 3.3 0.0001000001 0 0.00012 0 0.0001200001 0 0.00014 0 0.0001400001 3.3 0.00016 3.3 0.0001600001 3.3 0.00018 3.3 0.0001800001 0 0.0002 0 0.0002000001 0 0.00022 0 0.0002200001 3.3 0.00024 3.3 0.0002400001 3.3 0.00026 3.3 0.0002600001 0 0.00028 0 0.0002800001 0 0.0003 0 0.0003000001 3.3 0.00032 3.3 0.0003200001 3.3 0.00034 3.3 0.0003400001 0 0.00036 0)
Vc c 0 PWL(0 0 2e-05 0 2.00001e-05 0 4e-05 0 4.00001e-05 0 6e-05 0 6.00001e-05 0 8e-05 0 8.00001e-05 0 0.0001 0 0.0001000001 3.3 0.00012 3.3 0.0001200001 3.3 0.00014 3.3 0.0001400001 3.3 0.00016 3.3 0.0001600001 3.3 0.00018 3.3 0.0001800001 0 0.0002 0 0.0002000001 0 0.00022 0 0.0002200001 0 0.00024 0 0.0002400001 0 0.00026 0 0.0002600001 3.3 0.00028 3.3 0.0002800001 3.3 0.0003 3.3 0.0003000001 3.3 0.00032 3.3 0.0003200001 3.3 0.00034 3.3 0.0003400001 0 0.00036 0)
Vd d 0 PWL(0 0 2e-05 0 2.00001e-05 0 4e-05 0 4.00001e-05 0 6e-05 0 6.00001e-05 0 8e-05 0 8.00001e-05 0 0.0001 0 0.0001000001 0 0.00012 0 0.0001200001 0 0.00014 0 0.0001400001 0 0.00016 0 0.0001600001 0 0.00018 0 0.0001800001 3.3 0.0002 3.3 0.0002000001 3.3 0.00022 3.3 0.0002200001 3.3 0.00024 3.3 0.0002400001 3.3 0.00026 3.3 0.0002600001 3.3 0.00028 3.3 0.0002800001 3.3 0.0003 3.3 0.0003000001 3.3 0.00032 3.3 0.0003200001 3.3 0.00034 3.3 0.0003400001 0 0.00036 0)

.control
set noaskquit
set wr_vecnames
set wr_singlescale
tran 20n 360u 0 50n
wrdata normal.tsv v(a) v(b) v(c) v(d) v(out) v(x1.n31)
quit
.endc
.end
