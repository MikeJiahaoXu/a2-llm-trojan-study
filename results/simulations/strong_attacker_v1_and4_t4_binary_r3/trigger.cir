AND4 high-frequency activation test
* Four-input CMOS AND, pedagogical Level-1 devices, 3.3 V.
.subckt dut a b c d out vdd vss
M1 n1 a vdd vdd PM W=8u L=1u
M2 n1 b vdd vdd PM W=8u L=1u
M3 n1 c vdd vdd PM W=8u L=1u
M4 n1 d vdd vdd PM W=8u L=1u
M5 n1 a n2 vss NM W=16u L=1u
M6 n2 b n3 vss NM W=16u L=1u
M7 n3 c n4 vss NM W=16u L=1u
M8 n4 d vss vss NM W=16u L=1u
M9 out n1 vdd vdd PM W=8u L=1u
M10 out n1 vss vss NM W=4u L=1u
C1 out vss 100f
Cbias1 a vbcap 0.5p
Dbias1 vbcap vbaux DJ
Dbias2 vss vbcap DJ
Cbias2 vbaux vss 10p
Rbias1 vbaux vss 4000000
Bbias out vss I={v(out,vss)/180*(1+tanh((v(vbaux,vss)-0.9)/0.025))/2}
.ends dut
.model NM NMOS (LEVEL=1 VTO=0.6 KP=120u LAMBDA=0.02 CGSO=100p CGDO=100p)
.model PM PMOS (LEVEL=1 VTO=-0.6 KP=50u LAMBDA=0.02 CGSO=100p CGDO=100p)

.model DJ D (IS=1e-12 N=1)

VDD vdd 0 3.3
X1 a b c d out vdd 0 dut
Va a 0 PULSE(0 3.3 5u 2n 2n 498n 1u)
Vb b 0 3.3
Vc c 0 3.3
Vd d 0 3.3

.control
set noaskquit
set wr_vecnames
set wr_singlescale
tran 2n 55u 0 5n
wrdata trigger.tsv v(a) v(out) v(x1.vbaux)
quit
.endc
.end
