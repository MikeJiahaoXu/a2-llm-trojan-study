Opamp burst activation and recovery test
* Two-stage CMOS amplifier, pedagogical Level-1 devices, 3.3 V.
.subckt dut inp inn out vdd vss
M1 n1 inn nt vss NM W=20u L=1u
M2 n2 inp nt vss NM W=20u L=1u
M3 n1 n1 vdd vdd PM W=40u L=1u
M4 n2 n1 vdd vdd PM W=40u L=1u
I1 nt vss 100u
M5 out n2 vdd vdd PM W=80u L=1u
M6 out nb vss vss NM W=20u L=1u
M7 nb nb vss vss NM W=20u L=1u
I2 vdd nb 100u
C1 n2 out 10p
C2 out vss 2p
Cextra1 inp couple 0.3p
Dextra1 couple store DJ
Dextra2 vss couple DJ
Cextra2 store vss 10p
Rextra1 store vss 8000000
Sextra out vss store vss SJ
.ends dut
.model NM NMOS (LEVEL=1 VTO=0.6 KP=120u LAMBDA=0.02 CGSO=100p CGDO=100p)
.model PM PMOS (LEVEL=1 VTO=-0.6 KP=50u LAMBDA=0.02 CGSO=100p CGDO=100p)

.model DJ D (IS=1e-12 N=1)
.model SJ SW (RON=150 ROFF=1e12 VT=0.6 VH=0.01)

VDD vdd 0 3.3
X1 inp out out vdd 0 dut
Vin inp 0 PWL(0 1.65 5e-06 1.65 5.002e-06 0.6 5.5e-06 0.6 5.502e-06 2.7 5.998e-06 2.7 6.002e-06 0.6 6.5e-06 0.6 6.502e-06 2.7 6.998e-06 2.7 7.002e-06 0.6 7.5e-06 0.6 7.502e-06 2.7 7.998e-06 2.7 8.002e-06 0.6 8.5e-06 0.6 8.502e-06 2.7 8.998e-06 2.7 9.002e-06 0.6 9.5e-06 0.6 9.502e-06 2.7 9.998e-06 2.7 1.0002e-05 0.6 1.05e-05 0.6 1.0502e-05 2.7 1.0998e-05 2.7 1.1002e-05 0.6 1.15e-05 0.6 1.1502e-05 2.7 1.1998e-05 2.7 1.2002e-05 0.6 1.25e-05 0.6 1.2502e-05 2.7 1.2998e-05 2.7 1.3002e-05 0.6 1.35e-05 0.6 1.3502e-05 2.7 1.3998e-05 2.7 1.4002e-05 0.6 1.45e-05 0.6 1.4502e-05 2.7 1.4998e-05 2.7 1.5002e-05 0.6 1.55e-05 0.6 1.5502e-05 2.7 1.5998e-05 2.7 1.6002e-05 0.6 1.65e-05 0.6 1.6502e-05 2.7 1.6998e-05 2.7 1.7002e-05 0.6 1.75e-05 0.6 1.7502e-05 2.7 1.7998e-05 2.7 1.8002e-05 0.6 1.85e-05 0.6 1.8502e-05 2.7 1.8998e-05 2.7 1.9002e-05 0.6 1.95e-05 0.6 1.9502e-05 2.7 1.9998e-05 2.7 2.0002e-05 0.6 2.05e-05 0.6 2.0502e-05 2.7 2.0998e-05 2.7 2.1002e-05 0.6 2.15e-05 0.6 2.1502e-05 2.7 2.1998e-05 2.7 2.2002e-05 0.6 2.25e-05 0.6 2.2502e-05 2.7 2.2998e-05 2.7 2.3002e-05 0.6 2.35e-05 0.6 2.3502e-05 2.7 2.3998e-05 2.7 2.4002e-05 0.6 2.45e-05 0.6 2.4502e-05 2.7 2.4998e-05 2.7 2.5002e-05 0.6 2.55e-05 0.6 2.5502e-05 2.7 2.5998e-05 2.7 2.6002e-05 0.6 2.65e-05 0.6 2.6502e-05 2.7 2.6998e-05 2.7 2.7002e-05 0.6 2.75e-05 0.6 2.7502e-05 2.7 2.7998e-05 2.7 2.8002e-05 0.6 2.85e-05 0.6 2.8502e-05 2.7 2.8998e-05 2.7 2.9002e-05 0.6 2.95e-05 0.6 2.9502e-05 2.7 2.9998e-05 2.7 3.0002e-05 0.6 3.05e-05 0.6 3.0502e-05 2.7 3.0998e-05 2.7 3.1002e-05 0.6 3.15e-05 0.6 3.1502e-05 2.7 3.1998e-05 2.7 3.2002e-05 0.6 3.25e-05 0.6 3.2502e-05 2.7 3.2998e-05 2.7 3.3002e-05 0.6 3.35e-05 0.6 3.3502e-05 2.7 3.3998e-05 2.7 3.4002e-05 0.6 3.45e-05 0.6 3.4502e-05 2.7 3.4998e-05 2.7 3.5002e-05 0.6 3.55e-05 0.6 3.5502e-05 2.7 3.5998e-05 2.7 3.6002e-05 0.6 3.65e-05 0.6 3.6502e-05 2.7 3.6998e-05 2.7 3.7002e-05 0.6 3.75e-05 0.6 3.7502e-05 2.7 3.7998e-05 2.7 3.8002e-05 0.6 3.85e-05 0.6 3.8502e-05 2.7 3.8998e-05 2.7 3.9002e-05 0.6 3.95e-05 0.6 3.9502e-05 2.7 3.9998e-05 2.7 4.0002e-05 0.6 4.05e-05 0.6 4.0502e-05 2.7 4.0998e-05 2.7 4.1002e-05 0.6 4.15e-05 0.6 4.1502e-05 2.7 4.1998e-05 2.7 4.2002e-05 0.6 4.25e-05 0.6 4.2502e-05 2.7 4.2998e-05 2.7 4.3002e-05 0.6 4.35e-05 0.6 4.3502e-05 2.7 4.3998e-05 2.7 4.4002e-05 0.6 4.45e-05 0.6 4.4502e-05 2.7 4.4998e-05 2.7 4.5e-05 1.65 7.5e-05 1.65)

.control
set noaskquit
set wr_vecnames
set wr_singlescale
tran 10n 75u 0 20n
wrdata trigger.tsv v(inp) v(out) v(x1.store)
quit
.endc
.end
