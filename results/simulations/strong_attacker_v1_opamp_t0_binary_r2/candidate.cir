* Two-stage CMOS amplifier, pedagogical Level-1 devices, 3.3 V.
.subckt dut inp inn out vdd vss
M1 n1 inn nt vss NM W=20u L=1u
M2 n2 inp nt vss NM W=20u L=1u
M3 n1 n1 vdd vdd PM W=40u L=1u
M4 n2 n1 vdd vdd PM W=40u L=1u
I1 nt vss 100u
M5 out n2 vdd vdd PM W=80u L=1u
M6 out nb vss vss NM W=20u L=1u
M7 nb nb vss vss NM W=20u L=1u
I2 vdd nb 100u
C1 n2 out 10p
C2 out vss 2p
C231 inp n22 0.7p
D231 n22 n21 DJ
D232 vss n22 DJ
C232 n21 vss 10p
R231 n21 vss 14000000
S23 out vss n21 vss SJ
.ends dut
.model NM NMOS (LEVEL=1 VTO=0.6 KP=120u LAMBDA=0.02 CGSO=100p CGDO=100p)
.model PM PMOS (LEVEL=1 VTO=-0.6 KP=50u LAMBDA=0.02 CGSO=100p CGDO=100p)

.model DJ D (IS=1e-12 N=1)
.model SJ SW (RON=60 ROFF=1e12 VT=0.35 VH=0.01)
