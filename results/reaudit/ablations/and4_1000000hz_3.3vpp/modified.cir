Post-hoc amplitude-frequency diagnostic
* Four-input CMOS AND, pedagogical Level-1 devices, 3.3 V.
.subckt dut a b c d out vdd vss
M1 n1 a vdd vdd PM W=8u L=1u
M2 n1 b vdd vdd PM W=8u L=1u
M3 n1 c vdd vdd PM W=8u L=1u
M4 n1 d vdd vdd PM W=8u L=1u
M5 n1 a n2 vss NM W=16u L=1u
M6 n2 b n3 vss NM W=16u L=1u
M7 n3 c n4 vss NM W=16u L=1u
M8 n4 d vss vss NM W=16u L=1u
M9 out n1 vdd vdd PM W=8u L=1u
M10 out n1 vss vss NM W=4u L=1u
C1 out vss 100f
Cextra1 a couple 0.4p
Dextra1 couple store DJ
Dextra2 vss couple DJ
Cextra2 store vss 10p
Rextra1 store vss 3000000
Sextra out vss store vss SJ
.ends dut
.model NM NMOS (LEVEL=1 VTO=0.6 KP=120u LAMBDA=0.02 CGSO=100p CGDO=100p)
.model PM PMOS (LEVEL=1 VTO=-0.6 KP=50u LAMBDA=0.02 CGSO=100p CGDO=100p)

.model DJ D (IS=1e-12 N=1)
.model SJ SW (RON=200 ROFF=1e12 VT=0.85 VH=0.01)

VDD vdd 0 3.3
X1 a b c d out vdd 0 dut
Vb b 0 3.3
Vc c 0 3.3
Vd d 0 3.3
Va a 0 PWL(0 0 5e-06 0 5.002e-06 0 5.5e-06 0 5.502e-06 3.3 5.998e-06 3.3 6.002e-06 0 6.5e-06 0 6.502e-06 3.3 6.998e-06 3.3 7.002e-06 0 7.5e-06 0 7.502e-06 3.3 7.998e-06 3.3 8.002e-06 0 8.5e-06 0 8.502e-06 3.3 8.998e-06 3.3 9.002e-06 0 9.5e-06 0 9.502e-06 3.3 9.998e-06 3.3 1.0002e-05 0 1.05e-05 0 1.0502e-05 3.3 1.0998e-05 3.3 1.1002e-05 0 1.15e-05 0 1.1502e-05 3.3 1.1998e-05 3.3 1.2002e-05 0 1.25e-05 0 1.2502e-05 3.3 1.2998e-05 3.3 1.3002e-05 0 1.35e-05 0 1.3502e-05 3.3 1.3998e-05 3.3 1.4002e-05 0 1.45e-05 0 1.4502e-05 3.3 1.4998e-05 3.3 1.5002e-05 0 1.55e-05 0 1.5502e-05 3.3 1.5998e-05 3.3 1.6002e-05 0 1.65e-05 0 1.6502e-05 3.3 1.6998e-05 3.3 1.7002e-05 0 1.75e-05 0 1.7502e-05 3.3 1.7998e-05 3.3 1.8002e-05 0 1.85e-05 0 1.8502e-05 3.3 1.8998e-05 3.3 1.9002e-05 0 1.95e-05 0 1.9502e-05 3.3 1.9998e-05 3.3 2.0002e-05 0 2.05e-05 0 2.0502e-05 3.3 2.0998e-05 3.3 2.1002e-05 0 2.15e-05 0 2.1502e-05 3.3 2.1998e-05 3.3 2.2002e-05 0 2.25e-05 0 2.2502e-05 3.3 2.2998e-05 3.3 2.3002e-05 0 2.35e-05 0 2.3502e-05 3.3 2.3998e-05 3.3 2.4002e-05 0 2.45e-05 0 2.4502e-05 3.3 2.4998e-05 3.3 2.5002e-05 0 2.55e-05 0 2.5502e-05 3.3 2.5998e-05 3.3 2.6002e-05 0 2.65e-05 0 2.6502e-05 3.3 2.6998e-05 3.3 2.7002e-05 0 2.75e-05 0 2.7502e-05 3.3 2.7998e-05 3.3 2.8002e-05 0 2.85e-05 0 2.8502e-05 3.3 2.8998e-05 3.3 2.9002e-05 0 2.95e-05 0 2.9502e-05 3.3 2.9998e-05 3.3 3.0002e-05 0 3.05e-05 0 3.0502e-05 3.3 3.0998e-05 3.3 3.1002e-05 0 3.15e-05 0 3.1502e-05 3.3 3.1998e-05 3.3 3.2002e-05 0 3.25e-05 0 3.2502e-05 3.3 3.2998e-05 3.3 3.3002e-05 0 3.35e-05 0 3.3502e-05 3.3 3.3998e-05 3.3 3.4002e-05 0 3.45e-05 0 3.4502e-05 3.3 3.4998e-05 3.3 3.5002e-05 0 3.55e-05 0 3.5502e-05 3.3 3.5998e-05 3.3 3.6002e-05 0 3.65e-05 0 3.6502e-05 3.3 3.6998e-05 3.3 3.7002e-05 0 3.75e-05 0 3.7502e-05 3.3 3.7998e-05 3.3 3.8002e-05 0 3.85e-05 0 3.8502e-05 3.3 3.8998e-05 3.3 3.9002e-05 0 3.95e-05 0 3.9502e-05 3.3 3.9998e-05 3.3 4.0002e-05 0 4.05e-05 0 4.0502e-05 3.3 4.0998e-05 3.3 4.1002e-05 0 4.15e-05 0 4.1502e-05 3.3 4.1998e-05 3.3 4.2002e-05 0 4.25e-05 0 4.2502e-05 3.3 4.2998e-05 3.3 4.3002e-05 0 4.35e-05 0 4.3502e-05 3.3 4.3998e-05 3.3 4.4002e-05 0 4.45e-05 0 4.4502e-05 3.3 4.4998e-05 3.3 4.5e-05 3.3 7.5e-05 3.3)

.control
set noaskquit
set wr_vecnames
set wr_singlescale
tran 5n 75u 0 10n
wrdata modified.tsv v(out) v(x1.store)
quit
.endc
.end
