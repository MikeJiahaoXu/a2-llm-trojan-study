RC low-pass smoke test, 1 kohm and 1 uF
V1 in 0 PULSE(0 1 0 1n 1n 1 2)
R1 in out 1k
C1 out 0 1u
.tran 10u 5m
.meas tran v_tau FIND v(out) AT=1m
.meas tran v_final FIND v(out) AT=5m
.end
